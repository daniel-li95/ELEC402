// Design: ELEC402/Question2bA3TB
simulator lang=spectre
global 0
parameters T=5n VDD=1 vdd=1
include "/ubc/ece/data/cmc2/kits/AMSKIT616_GPDK/tech/gpdk045_v_4_0/gpdk045/../models/spectre/gpdk045.scs" section=tt

// ELEC402/Question2bA3/schematic
subckt Question2bA3 A B C D GND OUTPUT VDD
    NM3 (NM3_D D GND GND) g45n1svt w=(120n) l=45n nf=1 m=(1)
    NM2 (NM1_S C NM3_D GND) g45n1svt w=(120n) l=45n nf=1 m=(1)
    NM1 (OUTPUT B NM1_S GND) g45n1svt w=(120n) l=45n nf=1 m=(1)
    NM0 (OUTPUT A NM1_S GND) g45n1svt w=(120n) l=45n nf=1 m=(1)
    PM3 (OUTPUT D VDD VDD) g45p1svt w=(120n) l=45n nf=1 m=(1)
    PM2 (OUTPUT C VDD VDD) g45p1svt w=(120n) l=45n nf=1 m=(1)
    PM1 (OUTPUT A PM0_D VDD) g45p1svt w=(120n) l=45n nf=1 m=(1)
    PM0 (PM0_D B VDD VDD) g45p1svt w=(120n) l=45n nf=1 m=(1)
ends Question2bA3

// ELEC402/Question2bA3TB/schematic
I0 (V1_PLUS V2_PLUS V3_PLUS V4_PLUS 0 I0_OUTPUT I0_VDD) Question2bA3
C0 (I0_OUTPUT 0) capacitor c=10f
V0 (I0_VDD 0) vsource dc=VDD type=dc
V4 (V4_PLUS 0) vsource type=pulse val0=0 val1=vdd period=8*T rise=0.005*T fall=0.005*T
V3 (V3_PLUS 0) vsource type=pulse val0=0 val1=vdd period=4*T rise=0.005*T fall=0.005*T
V2 (V2_PLUS 0) vsource type=pulse val0=0 val1=vdd period=2*T rise=0.005*T fall=0.005*T
V1 (V1_PLUS 0) vsource type=pulse val0=0 val1=vdd period=1*T rise=0.005*T fall=0.005*T
simulatorOptions options temp=27
dcOp dc
tran tran stop=50n
