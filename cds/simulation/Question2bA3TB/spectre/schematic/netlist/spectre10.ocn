simulator( 'spectre )
design(	 "/ubc/ece/home/ugrads/v/v6d9/ELEC402/Modelsim_50995133/ELEC402/cds/simulation/Question2bA3TB/spectre/schematic/netlist/netlist")
resultsDir( "/ubc/ece/home/ugrads/v/v6d9/ELEC402/Modelsim_50995133/ELEC402/cds/simulation/Question2bA3TB/spectre/schematic" )
modelFile(
    '("/ubc/ece/data/cmc2/kits/AMSKIT616_GPDK/tech/gpdk045_v_4_0/gpdk045/../models/spectre/gpdk045.scs" "tt")
)
analysis('dc ?saveOppoint t  )
analysis('tran ?stop "5n"  )
desVar(	  "vdd" 1	)
desVar(	  "VDD" 1	)
desVar(	  "T" 500p	)
envOption(
	'analysisOrder  list("dc" "tran")
)
temp( 27 )
run()
selectResult( 'tran )
plot(getData("/V4_PLUS") getData("/I0_OUTPUT") getData("/V3_PLUS") getData("/V2_PLUS") getData("/V1_PLUS") )
selectResult( 'dcOp )
plot(getData("/V4_PLUS") getData("/I0_OUTPUT") getData("/V3_PLUS") getData("/V2_PLUS") getData("/V1_PLUS") )
modelFile(
    '("/ubc/ece/data/cmc2/kits/AMSKIT616_GPDK/tech/gpdk045_v_4_0/gpdk045/../models/spectre/gpdk045.scs" "tt")
)
run()
selectResult( 'tran )
plot(getData("/V1_PLUS") getData("/V2_PLUS") getData("/V3_PLUS") getData("/V4_PLUS") getData("/I0_OUTPUT") )
selectResult( 'dcOp )
plot(getData("/V1_PLUS") getData("/V2_PLUS") getData("/V3_PLUS") getData("/V4_PLUS") getData("/I0_OUTPUT") )
modelFile(
    '("/ubc/ece/data/cmc2/kits/AMSKIT616_GPDK/tech/gpdk045_v_4_0/gpdk045/../models/spectre/gpdk045.scs" "tt")
)
analysis('tran ?stop "30n"  )
desVar(	  "T" 2500p	)
run()
selectResult( 'tran )
plot(getData("/V1_PLUS") getData("/V2_PLUS") getData("/V3_PLUS") getData("/V4_PLUS") getData("/I0_OUTPUT") )
selectResult( 'dcOp )
plot(getData("/V1_PLUS") getData("/V2_PLUS") getData("/V3_PLUS") getData("/V4_PLUS") getData("/I0_OUTPUT") )
modelFile(
    '("/ubc/ece/data/cmc2/kits/AMSKIT616_GPDK/tech/gpdk045_v_4_0/gpdk045/../models/spectre/gpdk045.scs" "tt")
)
analysis('tran ?stop "50n"  )
desVar(	  "T" 5n	)
run()
selectResult( 'tran )
plot(getData("/V1_PLUS") getData("/V2_PLUS") getData("/V3_PLUS") getData("/V4_PLUS") getData("/I0_OUTPUT") )
selectResult( 'dcOp )
plot(getData("/V1_PLUS") getData("/V2_PLUS") getData("/V3_PLUS") getData("/V4_PLUS") getData("/I0_OUTPUT") )
