// Design: ELEC402/CELL_TB
simulator lang=spectre
global 0
parameters T=500p vdd=1
include "/ubc/ece/data/cmc2/kits/AMSKIT616_GPDK/tech/gpdk045_v_4_0/gpdk045/../models/spectre/gpdk045.scs" section=tt

// ELEC402/NMOS_PMOS_transistor/schematic
subckt NMOS_PMOS_transistor GND IN OUT VDD
    PM0 (OUT IN VDD VDD) g45p1svt w=(240n) l=45n nf=1 m=(1)
    NM0 (OUT IN GND GND) g45n1svt w=(120n) l=45n nf=1 m=(1)
ends NMOS_PMOS_transistor

// ELEC402/CELL_TB/schematic
V0 (V0_PLUS 0) vsource dc=vdd type=dc
C0 (I14_OUT 0) capacitor c=2f
I14 (0 V1_PLUS I14_OUT V0_PLUS) NMOS_PMOS_transistor
V1 (V1_PLUS 0) vsource type=pulse val0=0 val1=vdd period=T rise=0.1*T fall=0.1*T
simulatorOptions options temp=27
dcOp dc
tran tran stop=5n
