simulator( 'spectre )
design(	 "/ubc/ece/home/ugrads/v/v6d9/ELEC402/Modelsim_50995133/ELEC402/cds/simulation/CELL_TB/spectre/schematic/netlist/netlist")
resultsDir( "/ubc/ece/home/ugrads/v/v6d9/ELEC402/Modelsim_50995133/ELEC402/cds/simulation/CELL_TB/spectre/schematic" )
modelFile(
    '("/ubc/ece/data/cmc2/kits/AMSKIT616_GPDK/tech/gpdk045_v_4_0/gpdk045/../models/spectre/gpdk045.scs" "tt")
)
analysis('dc ?saveOppoint t  )
analysis('tran ?stop "5n"  )
desVar(	  "vdd" 1	)
desVar(	  "F" 2G	)
desVar(	  "CL" 10f	)
envOption(
	'analysisOrder  list("dc" "tran")
)
temp( 27 )
run()
modelFile(
    '("/ubc/ece/data/cmc2/kits/AMSKIT616_GPDK/tech/gpdk045_v_4_0/gpdk045/../models/spectre/gpdk045.scs" "tt")
)
run()
