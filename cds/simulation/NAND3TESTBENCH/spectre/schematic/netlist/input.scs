// Design: ELEC402/NAND3TESTBENCH
simulator lang=spectre
global 0
parameters T=10n
include "/ubc/ece/data/cmc2/kits/AMSKIT616_GPDK/tech/gpdk045_v_4_0/gpdk045/../models/spectre/gpdk045.scs" section=tt

// ELEC402/NAND3/schematic
subckt NAND3 A B C GND OUTPUT VDD
    NM2 (NM1_S C GND GND) g45n1svt w=(120n) l=45n nf=1 m=(1)
    NM1 (NM1_D B NM1_S GND) g45n1svt w=(120n) l=45n nf=1 m=(1)
    NM0 (OUTPUT A NM1_D GND) g45n1svt w=(120n) l=45n nf=1 m=(1)
    PM2 (OUTPUT C VDD VDD) g45p1svt w=(240n) l=45n nf=1 m=(1)
    PM1 (OUTPUT B VDD VDD) g45p1svt w=(240n) l=45n nf=1 m=(1)
    PM0 (OUTPUT A VDD VDD) g45p1svt w=(240n) l=45n nf=1 m=(1)
ends NAND3

// ELEC402/NAND3TESTBENCH/schematic
I0 (V2_PLUS V3_PLUS V1_PLUS 0 I0_OUTPUT V0_PLUS) NAND3
V0 (V0_PLUS 0) vsource dc=1 type=dc
V3 (V3_PLUS 0) vsource type=pulse val0=0 val1=1 period=2*T rise=0.1*T fall=0.1*T
V2 (V2_PLUS 0) vsource type=pulse val0=0 val1=1 period=4*T rise=0.1*T fall=0.1*T
V1 (V1_PLUS 0) vsource type=pulse val0=0 val1=1 period=1*T rise=0.1*T fall=0.1*T
C0 (0 I0_OUTPUT) capacitor c=10f
simulatorOptions options temp=27
dcOp dc
tran tran stop=500n
