simulator( 'spectre )
design(	 "/ubc/ece/home/ugrads/v/v6d9/ELEC402/Modelsim_50995133/ELEC402/cds/simulation/NAND3TESTBENCH/spectre/schematic/netlist/netlist")
resultsDir( "/ubc/ece/home/ugrads/v/v6d9/ELEC402/Modelsim_50995133/ELEC402/cds/simulation/NAND3TESTBENCH/spectre/schematic" )
modelFile(
    '("/ubc/ece/data/cmc2/kits/AMSKIT616_GPDK/tech/gpdk045_v_4_0/gpdk045/../models/spectre/gpdk045.scs" "tt")
)
analysis('dc ?saveOppoint t  )
analysis('tran ?stop "5m"  )
desVar(	  "T" 100n	)
envOption(
	'analysisOrder  list("dc" "tran")
)
temp( 27 )
run()
selectResult( 'tran )
plot(getData("/V2_PLUS") getData("/V3_PLUS") getData("/V1_PLUS") getData("/I0_OUTPUT") )
selectResult( 'dcOp )
plot(getData("/V2_PLUS") getData("/V3_PLUS") getData("/V1_PLUS") getData("/I0_OUTPUT") )
modelFile(
    '("/ubc/ece/data/cmc2/kits/AMSKIT616_GPDK/tech/gpdk045_v_4_0/gpdk045/../models/spectre/gpdk045.scs" "tt")
)
analysis('tran ?stop "500n"  )
desVar(	  "T" 10n	)
run()
selectResult( 'tran )
plot(getData("/V2_PLUS") getData("/V3_PLUS") getData("/V1_PLUS") getData("/I0_OUTPUT") )
selectResult( 'dcOp )
plot(getData("/V2_PLUS") getData("/V3_PLUS") getData("/V1_PLUS") getData("/I0_OUTPUT") )
modelFile(
    '("/ubc/ece/data/cmc2/kits/AMSKIT616_GPDK/tech/gpdk045_v_4_0/gpdk045/../models/spectre/gpdk045.scs" "tt")
)
run()
selectResult( 'tran )
plot(getData("/V2_PLUS") getData("/V3_PLUS") getData("/V1_PLUS") getData("/I0_OUTPUT") )
selectResult( 'dcOp )
plot(getData("/V2_PLUS") getData("/V3_PLUS") getData("/V1_PLUS") getData("/I0_OUTPUT") )
modelFile(
    '("/ubc/ece/data/cmc2/kits/AMSKIT616_GPDK/tech/gpdk045_v_4_0/gpdk045/../models/spectre/gpdk045.scs" "tt")
)
run()
selectResult( 'tran )
plot(getData("/V2_PLUS") getData("/V3_PLUS") getData("/V1_PLUS") getData("/I0_OUTPUT") )
selectResult( 'dcOp )
plot(getData("/V2_PLUS") getData("/V3_PLUS") getData("/V1_PLUS") getData("/I0_OUTPUT") )
